//-------------------------------------
// Generated by SIMECT
// Generated on: 06-May-2011 13:16:57
//-------------------------------------

`include "constants.vams"
`include "disciplines.vams"

module test_v_diff_i_uni (Vin1,Vin2,Vout);
input Vin1;
electrical Vin1;
input Vin2;
electrical Vin2;
output Vout;
electrical Vout;

parameter real Out_1_Num_TF_dir1_1_1  = -6.382952406239e-04 ;
parameter real Out_1_Num_TF_dir1_1_2  = -1.865209132334e-14 ;
parameter real Out_1_Num_TF_dir1_1_3  = -2.891627924441e-27 ;
parameter real Out_1_Den_TF_dir1_1_1  = 1.000000000000e+00 ;
parameter real Out_1_Den_TF_dir1_1_2  = 9.621419314472e-11 ;
parameter real Out_1_Den_TF_dir1_1_3  = 3.132313392602e-24 ;
parameter real Out_1_Num_TF_dir3_1_1  = 6.435489035437e-04 ;
parameter real Out_1_Num_TF_dir3_1_2  = 9.567718906029e-14 ;
parameter real Out_1_Num_TF_dir3_1_3  = -3.975971644185e-25 ;
parameter real Out_1_Den_TF_dir3_1_1  = 1.000000000000e+00 ;
parameter real Out_1_Den_TF_dir3_1_2  = 2.365869386389e-10 ;
parameter real Out_1_Den_TF_dir3_1_3  = 9.819312614588e-24 ;
parameter real Out_1_Num_TF_inv1_1_1  = -4.184695656605e-08 ;
parameter real Out_1_Num_TF_inv1_1_2  = -5.120591493976e-17 ;
parameter real Out_1_Den_TF_inv1_1_1  = 1.000000000000e+00 ;
parameter real Out_1_Den_TF_inv1_1_2  = 8.692232169418e-14 ;
parameter real Out_1_Den_TF_inv1_1_3  = 3.818216810059e-27 ;
parameter real Out_1_Num_TF_inv3_1_1  = 2.599411535755e-09 ;
parameter real Out_1_Num_TF_inv3_1_2  = -1.707786240565e-15 ;
parameter real Out_1_Num_TF_inv3_1_3  = -6.703670200199e-26 ;
parameter real Out_1_Den_TF_inv3_1_1  = 1.000000000000e+00 ;
parameter real Out_1_Den_TF_inv3_1_2  = 4.054694846162e-11 ;
parameter real Out_1_Den_TF_inv3_1_3  = 1.646642971882e-24 ;
parameter real Out_1_Num_Zin1_1_1  = 1.000000000000e+00 ;
parameter real Out_1_Num_Zin1_1_2  = 2.893318669891e-14 ;
parameter real Out_1_Num_Zin1_1_3  = 2.450059585818e-41 ;
parameter real Out_1_Den_Zin1_1_1  = 1.242578255775e-05 ;
parameter real Out_1_Den_Zin1_1_2  = 1.421833685887e-14 ;
parameter real Out_1_Num_Zin2_1_1  = 1.000000000000e+00 ;
parameter real Out_1_Num_Zin2_1_2  = 2.887872311313e-14 ;
parameter real Out_1_Den_Zin2_1_1  = 8.131049334413e-06 ;
parameter real Out_1_Den_Zin2_1_2  = 1.429005155715e-14 ;
parameter real Out_1_Num_Zin_diff1_1_1  = 1.000000000000e+00 ;
parameter real Out_1_Num_Zin_diff1_1_2  = 3.682570219954e-11 ;
parameter real Out_1_Num_Zin_diff1_1_3  = 4.732351155263e-24 ;
parameter real Out_1_Den_Zin_diff1_1_1  = 1.666008446512e-08 ;
parameter real Out_1_Den_Zin_diff1_1_2  = -6.617738601393e-15 ;
parameter real Out_1_Den_Zin_diff1_1_3  = -1.563189171752e-25 ;
parameter real Out_1_Num_Zin_diff2_1_1  = 1.000000000000e+00 ;
parameter real Out_1_Num_Zin_diff2_1_2  = 3.682570219954e-11 ;
parameter real Out_1_Num_Zin_diff2_1_3  = 4.732351155263e-24 ;
parameter real Out_1_Den_Zin_diff2_1_1  = 1.666008446512e-08 ;
parameter real Out_1_Den_Zin_diff2_1_2  = -6.617738601393e-15 ;
parameter real Out_1_Den_Zin_diff2_1_3  = -1.563189171752e-25 ;
parameter real Out_1_Num_Zout1_1_1  = 1.000000000000e+00 ;
parameter real Out_1_Num_Zout1_1_2  = 1.537288179971e-13 ;
parameter real Out_1_Num_Zout1_1_3  = 4.697232927446e-27 ;
parameter real Out_1_Den_Zout1_1_1  = 1.977611066977e-05 ;
parameter real Out_1_Den_Zout1_1_2  = 2.390770157746e-14 ;
parameter real Out_1_Den_Zout1_1_3  = 1.713603321547e-27 ;
parameter real Out_1_OffIn11 = 1.000000e+00;
parameter real Out_1_OffIn12 = 0.000000e+00;
parameter real Out_1_OffIn21 = 1.000000e+00;
parameter real Out_1_OffIn22 = 0.000000e+00;
parameter real Out_1_OffOut11 = 1.455432e-06;
parameter real Out_1_OffOut12 = 2.000000e+00;

real Vin1 ;
real Iin1 ;
real Vin2 ;
real Iin2 ;
real Vout1_1 ;
real Iout1_1 ;
real deltaVin1 ;
real deltaVin2 ;
real deltaVout1_1 ;

analog
begin

  Vin1 = V(Vin1,);
  I(Vin1,) <+ Iin1 ;
  Vin2 = V(Vin2,);
  I(Vin2,) <+ Iin2 ;
  Vout1_1 = V(Vout,);
  I(Vout,) <+ Iout1_1 ;

  deltaVin1 = Vin1 - Out_1_OffIn11;
  deltaVin2 = Vin2 - Out_1_OffIn21;
  deltaVout1_1 = Vout1_1 - Out_1_OffOut12;

  Iout1_1 = +laplace_nd(deltaVin1,{Out_1_Num_TF_dir1_1_1,Out_1_Num_TF_dir1_1_2,Out_1_Num_TF_dir1_1_3}, {Out_1_Den_TF_dir1_1_1,Out_1_Den_TF_dir1_1_2,Out_1_Den_TF_dir1_1_3}) +laplace_nd(deltaVin2,{Out_1_Num_TF_dir3_1_1,Out_1_Num_TF_dir3_1_2,Out_1_Num_TF_dir3_1_3}, {Out_1_Den_TF_dir3_1_1,Out_1_Den_TF_dir3_1_2,Out_1_Den_TF_dir3_1_3}) +laplace_nd(deltaVout1_1,{Out_1_Den_Zout1_1_1,Out_1_Den_Zout1_1_2,Out_1_Den_Zout1_1_3}, {Out_1_Num_Zout1_1_1,Out_1_Num_Zout1_1_2,Out_1_Num_Zout1_1_3}) + Out_1_OffOut11;
  Iin1 =  +laplace_nd(deltaVin1,{Out_1_Den_Zin1_1_1,Out_1_Den_Zin1_1_2}, {Out_1_Num_Zin1_1_1,Out_1_Num_Zin1_1_2,Out_1_Num_Zin1_1_3}) +laplace_nd(deltaVin2,{Out_1_Den_Zin_diff2_1_1,Out_1_Den_Zin_diff2_1_2,Out_1_Den_Zin_diff2_1_3}, {Out_1_Num_Zin_diff2_1_1,Out_1_Num_Zin_diff2_1_2,Out_1_Num_Zin_diff2_1_3}) +laplace_nd(deltaVout1_1,{Out_1_Num_TF_inv1_1_1,Out_1_Num_TF_inv1_1_2}, {Out_1_Den_TF_inv1_1_1,Out_1_Den_TF_inv1_1_2,Out_1_Den_TF_inv1_1_3})+ Out_1_OffIn12;
  Iin2 =  +laplace_nd(deltaVin2,{Out_1_Den_Zin2_1_1,Out_1_Den_Zin2_1_2}, {Out_1_Num_Zin2_1_1,Out_1_Num_Zin2_1_2}) +laplace_nd(deltaVin1,{Out_1_Den_Zin_diff1_1_1,Out_1_Den_Zin_diff1_1_2,Out_1_Den_Zin_diff1_1_3}, {Out_1_Num_Zin_diff1_1_1,Out_1_Num_Zin_diff1_1_2,Out_1_Num_Zin_diff1_1_3}) +laplace_nd(deltaVout1_1,{Out_1_Num_TF_inv3_1_1,Out_1_Num_TF_inv3_1_2,Out_1_Num_TF_inv3_1_3}, {Out_1_Den_TF_inv3_1_1,Out_1_Den_TF_inv3_1_2,Out_1_Den_TF_inv3_1_3})+ Out_1_OffIn22;

end
endmodule
