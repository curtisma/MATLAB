//-------------------------------------
// Generated by SIMECT
// Generated on: 06-May-2011 12:34:51
//-------------------------------------

`include "constants.vams"
`include "disciplines.vams"

module test_v_uni_v_uni (Vin,Vout);
input Vin;
electrical Vin;
output Vout;
electrical Vout;

parameter real Out_1_Num_TF_dir1_1_1  = 8.080523521257e-01 ;
parameter real Out_1_Num_TF_dir1_1_2  = 1.905564763746e-11 ;
parameter real Out_1_Num_TF_dir1_1_3  = 8.808222705263e-25 ;
parameter real Out_1_Den_TF_dir1_1_1  = 1.000000000000e+00 ;
parameter real Out_1_Den_TF_dir1_1_2  = 2.773341596048e-11 ;
parameter real Out_1_Den_TF_dir1_1_3  = 1.281666983644e-24 ;
parameter real Out_1_Num_TF_inv1_1_1  = 1.205085427387e-18 ;
parameter real Out_1_Num_TF_inv1_1_2  = -2.038412441016e-11 ;
parameter real Out_1_Num_TF_inv1_1_3  = -9.428140963994e-25 ;
parameter real Out_1_Den_TF_inv1_1_1  = 1.000000000000e+00 ;
parameter real Out_1_Den_TF_inv1_1_2  = 2.773341596048e-11 ;
parameter real Out_1_Den_TF_inv1_1_3  = 1.281666983645e-24 ;
parameter real Out_1_Num_Zin1_1_1  = 1.000000000000e+00 ;
parameter real Out_1_Num_Zin1_1_2  = 3.065889192376e-11 ;
parameter real Out_1_Num_Zin1_1_3  = 9.754989298025e-26 ;
parameter real Out_1_Den_Zin1_1_1  = 1.224613729992e-07 ;
parameter real Out_1_Den_Zin1_1_2  = 1.345960955964e-14 ;
parameter real Out_1_Den_Zin1_1_3  = 5.791872311970e-25 ;
parameter real Out_1_Num_Zout1_1_1  = 1.000000000000e+00 ;
parameter real Out_1_Num_Zout1_1_2  = 3.078829908835e-13 ;
parameter real Out_1_Num_Zout1_1_3  = 1.649751531738e-26 ;
parameter real Out_1_Den_Zout1_1_1  = 2.053538290091e-03 ;
parameter real Out_1_Den_Zout1_1_2  = 5.699844142106e-14 ;
parameter real Out_1_Den_Zout1_1_3  = 3.927981974514e-27 ;
parameter real Out_1_OffIn11 = 1.500000e+00;
parameter real Out_1_OffIn12 = 0.000000e+00;
parameter real Out_1_OffOut11 = 5.432017e-01;
parameter real Out_1_OffOut12 = 0.000000e+00;

real Vin1 ;
real Iin1 ;
real Vout1_1 ;
real Iout1_1 ;
real deltaVin1 ;
real deltaIout1_1 ;

analog
begin

  Vin1 = V(Vin,);
  I(Vin,) <+ Iin1 ;
  Iout1_1 = I(Vout,);
  V(Vout,) <+ Vout1_1 ;

  deltaVin1 = Vin1 - Out_1_OffIn11;
  deltaIout1_1 = Iout1_1 - Out_1_OffOut12;

  Vout1_1 = +laplace_nd(deltaVin1,{Out_1_Num_TF_dir1_1_1,Out_1_Num_TF_dir1_1_2,Out_1_Num_TF_dir1_1_3}, {Out_1_Den_TF_dir1_1_1,Out_1_Den_TF_dir1_1_2,Out_1_Den_TF_dir1_1_3}) +laplace_nd(deltaIout1_1,{Out_1_Num_Zout1_1_1,Out_1_Num_Zout1_1_2,Out_1_Num_Zout1_1_3}, {Out_1_Den_Zout1_1_1,Out_1_Den_Zout1_1_2,Out_1_Den_Zout1_1_3}) + Out_1_OffOut11;
  Iin1 =  +laplace_nd(deltaVin1,{Out_1_Den_Zin1_1_1,Out_1_Den_Zin1_1_2,Out_1_Den_Zin1_1_3}, {Out_1_Num_Zin1_1_1,Out_1_Num_Zin1_1_2,Out_1_Num_Zin1_1_3}) +laplace_nd(deltaIout1_1,{Out_1_Num_TF_inv1_1_1,Out_1_Num_TF_inv1_1_2,Out_1_Num_TF_inv1_1_3}, {Out_1_Den_TF_inv1_1_1,Out_1_Den_TF_inv1_1_2,Out_1_Den_TF_inv1_1_3})+ Out_1_OffIn12;

end
endmodule
