//-------------------------------------
// Generated by SIMECT
// Generated on: 06-May-2011 13:32:26
//-------------------------------------

`include "constants.vams"
`include "disciplines.vams"

module test_i_diff_i_diff (Vin1,Vin2,Vout1,Vout2);
input Vin1;
electrical Vin1;
input Vin2;
electrical Vin2;
output Vout1;
electrical Vout1;
output Vout2;
electrical Vout2;

parameter real Out_1_Num_TF_dir1_1_1  = -4.942364798317e-01 ;
parameter real Out_1_Num_TF_dir1_1_2  = 3.619091945274e-12 ;
parameter real Out_1_Num_TF_dir1_1_3  = -5.910993949171e-24 ;
parameter real Out_1_Den_TF_dir1_1_1  = 1.000000000000e+00 ;
parameter real Out_1_Den_TF_dir1_1_2  = 9.209412151044e-11 ;
parameter real Out_1_Den_TF_dir1_1_3  = 1.993695527241e-21 ;
parameter real Out_1_Num_TF_dir2_1_1  = 5.132056575945e-01 ;
parameter real Out_1_Num_TF_dir2_1_2  = -3.606639541675e-12 ;
parameter real Out_1_Num_TF_dir2_1_3  = 6.008142911821e-24 ;
parameter real Out_1_Den_TF_dir2_1_1  = 1.000000000000e+00 ;
parameter real Out_1_Den_TF_dir2_1_2  = 9.587804145951e-11 ;
parameter real Out_1_Den_TF_dir2_1_3  = 2.223253237730e-21 ;
parameter real Out_1_Num_TF_dir3_1_1  = 5.073520996927e-01 ;
parameter real Out_1_Num_TF_dir3_1_2  = -3.692566018699e-12 ;
parameter real Out_1_Num_TF_dir3_1_3  = 6.398161330145e-24 ;
parameter real Out_1_Den_TF_dir3_1_1  = 1.000000000000e+00 ;
parameter real Out_1_Den_TF_dir3_1_2  = 9.619812843732e-11 ;
parameter real Out_1_Den_TF_dir3_1_3  = 2.312388602691e-21 ;
parameter real Out_1_Num_TF_dir4_1_1  = -4.844657916512e-01 ;
parameter real Out_1_Num_TF_dir4_1_2  = 3.613096677274e-12 ;
parameter real Out_1_Num_TF_dir4_1_3  = -6.046868793534e-24 ;
parameter real Out_1_Den_TF_dir4_1_1  = 1.000000000000e+00 ;
parameter real Out_1_Den_TF_dir4_1_2  = 9.167374877558e-11 ;
parameter real Out_1_Den_TF_dir4_1_3  = 2.028564017957e-21 ;
parameter real Out_1_Num_TF_inv1_1_1  = -3.486167165689e-07 ;
parameter real Out_1_Num_TF_inv1_1_2  = 8.382255405588e-17 ;
parameter real Out_1_Den_TF_inv1_1_1  = 1.000000000000e+00 ;
parameter real Out_1_Den_TF_inv1_1_2  = 4.482782965400e-12 ;
parameter real Out_1_Num_TF_inv2_1_1  = -2.433532472643e-06 ;
parameter real Out_1_Num_TF_inv2_1_2  = 2.406536756445e-15 ;
parameter real Out_1_Den_TF_inv2_1_1  = 1.000000000000e+00 ;
parameter real Out_1_Den_TF_inv2_1_2  = 2.152929623931e-11 ;
parameter real Out_1_Den_TF_inv2_1_3  = 1.311806131097e-22 ;
parameter real Out_1_Num_TF_inv3_1_1  = -2.694294811423e-06 ;
parameter real Out_1_Num_TF_inv3_1_2  = 2.737893116976e-15 ;
parameter real Out_1_Den_TF_inv3_1_1  = 1.000000000000e+00 ;
parameter real Out_1_Den_TF_inv3_1_2  = 2.233163074851e-11 ;
parameter real Out_1_Den_TF_inv3_1_3  = 1.411564217149e-22 ;
parameter real Out_1_Num_TF_inv4_1_1  = -3.751634040420e-07 ;
parameter real Out_1_Num_TF_inv4_1_2  = 8.969411956430e-17 ;
parameter real Out_1_Den_TF_inv4_1_1  = 1.000000000000e+00 ;
parameter real Out_1_Den_TF_inv4_1_2  = 4.470818653026e-12 ;
parameter real Out_1_Num_Zin1_1_1  = 1.000000000000e+00 ;
parameter real Out_1_Num_Zin1_1_2  = 6.678475090746e-11 ;
parameter real Out_1_Den_Zin1_1_1  = 9.391496064130e-02 ;
parameter real Out_1_Den_Zin1_1_2  = 1.477287883452e-12 ;
parameter real Out_1_Den_Zin1_1_3  = 1.148437913563e-26 ;
parameter real Out_1_Num_Zin2_1_1  = 1.000000000000e+00 ;
parameter real Out_1_Num_Zin2_1_2  = 7.957696351986e-11 ;
parameter real Out_1_Den_Zin2_1_1  = 9.675197210992e-02 ;
parameter real Out_1_Den_Zin2_1_2  = 1.774069010995e-12 ;
parameter real Out_1_Num_Zin_diff1_1_1  = 0.000000000000e+00 ;
parameter real Out_1_Den_Zin_diff1_1_1  = 1.000000000000e+00 ;
parameter real Out_1_Num_Zin_diff2_1_1  = 0.000000000000e+00 ;
parameter real Out_1_Den_Zin_diff2_1_1  = 1.000000000000e+00 ;
parameter real Out_1_Num_Zout1_1_1  = 1.000000000000e+00 ;
parameter real Out_1_Num_Zout1_1_2  = 3.167267728687e-13 ;
parameter real Out_1_Num_Zout1_1_3  = 1.225675234239e-26 ;
parameter real Out_1_Den_Zout1_1_1  = 1.732293643995e-04 ;
parameter real Out_1_Den_Zout1_1_2  = 2.522576573002e-14 ;
parameter real Out_1_Den_Zout1_1_3  = 6.736633293931e-27 ;
parameter real Out_1_Num_Zout2_1_1  = 1.000000000000e+00 ;
parameter real Out_1_Num_Zout2_1_2  = 3.144998826705e-13 ;
parameter real Out_1_Num_Zout2_1_3  = 1.214650787950e-26 ;
parameter real Out_1_Den_Zout2_1_1  = 1.670640056852e-04 ;
parameter real Out_1_Den_Zout2_1_2  = 2.521866886640e-14 ;
parameter real Out_1_Den_Zout2_1_3  = 6.681625484108e-27 ;
parameter real Out_1_OffIn11 = -1.000000e-04;
parameter real Out_1_OffIn12 = 2.139866e+00;
parameter real Out_1_OffIn21 = 1.000000e-04;
parameter real Out_1_OffIn22 = 2.137801e+00;
parameter real Out_1_OffOut11 = 4.566877e-05;
parameter real Out_1_OffOut12 = 2.250000e+00;
parameter real Out_1_OffOut21 = -1.543486e-04;
parameter real Out_1_OffOut22 = 2.250000e+00;

real Vin1 ;
real Iin1 ;
real Vin2 ;
real Iin2 ;
real Vout1_1 ;
real Iout1_1 ;
real Vout2_1 ;
real Iout2_1 ;
real deltaIin1 ;
real deltaIin2 ;
real deltaVout1_1 ;
real deltaVout2_1 ;

analog
begin

  Iin1 = I(Vin1,);
  V(Vin1,) <+ Vin1 ;
  Iin2 = I(Vin2,);
  V(Vin2,) <+ Vin2 ;
  Vout1_1 = V(Vout1,);
  I(Vout1,) <+ Iout1_1 ;
  Vout2_1 = V(Vout2,);
  I(Vout2,) <+ Iout2_1 ;

  deltaIin1 = Iin1 - Out_1_OffIn11;
  deltaIin2 = Iin2 - Out_1_OffIn21;
  deltaVout1_1 = Vout1_1 - Out_1_OffOut12;
  deltaVout2_1 = Vout2_1 - Out_1_OffOut22;

  Iout1_1 = +laplace_nd(deltaIin1,{Out_1_Num_TF_dir1_1_1,Out_1_Num_TF_dir1_1_2,Out_1_Num_TF_dir1_1_3}, {Out_1_Den_TF_dir1_1_1,Out_1_Den_TF_dir1_1_2,Out_1_Den_TF_dir1_1_3}) +laplace_nd(deltaIin2,{Out_1_Num_TF_dir3_1_1,Out_1_Num_TF_dir3_1_2,Out_1_Num_TF_dir3_1_3}, {Out_1_Den_TF_dir3_1_1,Out_1_Den_TF_dir3_1_2,Out_1_Den_TF_dir3_1_3}) +laplace_nd(deltaVout1_1,{Out_1_Den_Zout1_1_1,Out_1_Den_Zout1_1_2,Out_1_Den_Zout1_1_3}, {Out_1_Num_Zout1_1_1,Out_1_Num_Zout1_1_2,Out_1_Num_Zout1_1_3}) + Out_1_OffOut11;
  Iout2_1 = +laplace_nd(deltaIin1,{Out_1_Num_TF_dir2_1_1,Out_1_Num_TF_dir2_1_2,Out_1_Num_TF_dir2_1_3}, {Out_1_Den_TF_dir2_1_1,Out_1_Den_TF_dir2_1_2,Out_1_Den_TF_dir2_1_3}) +laplace_nd(deltaIin2,{Out_1_Num_TF_dir4_1_1,Out_1_Num_TF_dir4_1_2,Out_1_Num_TF_dir4_1_3}, {Out_1_Den_TF_dir4_1_1,Out_1_Den_TF_dir4_1_2,Out_1_Den_TF_dir4_1_3}) +laplace_nd(deltaVout2_1,{Out_1_Den_Zout2_1_1,Out_1_Den_Zout2_1_2,Out_1_Den_Zout2_1_3}, {Out_1_Num_Zout2_1_1,Out_1_Num_Zout2_1_2,Out_1_Num_Zout2_1_3}) + Out_1_OffOut21;
  Vin1 =  +laplace_nd(deltaIin1,{Out_1_Num_Zin1_1_1,Out_1_Num_Zin1_1_2}, {Out_1_Den_Zin1_1_1,Out_1_Den_Zin1_1_2,Out_1_Den_Zin1_1_3}) +0.0 +laplace_nd(deltaVout1_1,{Out_1_Num_TF_inv1_1_1,Out_1_Num_TF_inv1_1_2}, {Out_1_Den_TF_inv1_1_1,Out_1_Den_TF_inv1_1_2}) +laplace_nd(deltaVout2_1,{Out_1_Num_TF_inv2_1_1,Out_1_Num_TF_inv2_1_2}, {Out_1_Den_TF_inv2_1_1,Out_1_Den_TF_inv2_1_2,Out_1_Den_TF_inv2_1_3})+ Out_1_OffIn12;
  Vin2 =  +laplace_nd(deltaIin2,{Out_1_Num_Zin2_1_1,Out_1_Num_Zin2_1_2}, {Out_1_Den_Zin2_1_1,Out_1_Den_Zin2_1_2}) +0.0 +laplace_nd(deltaVout1_1,{Out_1_Num_TF_inv3_1_1,Out_1_Num_TF_inv3_1_2}, {Out_1_Den_TF_inv3_1_1,Out_1_Den_TF_inv3_1_2,Out_1_Den_TF_inv3_1_3}) +laplace_nd(deltaVout2_1,{Out_1_Num_TF_inv4_1_1,Out_1_Num_TF_inv4_1_2}, {Out_1_Den_TF_inv4_1_1,Out_1_Den_TF_inv4_1_2})+ Out_1_OffIn22;

end
endmodule
