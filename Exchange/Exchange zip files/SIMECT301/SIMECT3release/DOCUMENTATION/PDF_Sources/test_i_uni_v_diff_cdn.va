//-------------------------------------
// Generated by SIMECT
// Generated on: 06-May-2011 13:25:36
//-------------------------------------

`include "constants.vams"
`include "disciplines.vams"

module test_i_uni_v_diff (Vin,Vout1,Vout2);
input Vin;
electrical Vin;
output Vout1;
electrical Vout1;
output Vout2;
electrical Vout2;

parameter real Out_1_Num_TF_dir1_1_1  = 1.000000000000e+00 ;
parameter real Out_1_Den_TF_dir1_1_1  = 4.470028399999e-03 ;
parameter real Out_1_Den_TF_dir1_1_2  = 5.733292492384e-13 ;
parameter real Out_1_Den_TF_dir1_1_3  = 3.408664392785e-23 ;
parameter real Out_1_Num_TF_dir2_1_1  = -1.000000000000e+00 ;
parameter real Out_1_Num_TF_dir2_1_2  = 2.445868599598e-11 ;
parameter real Out_1_Den_TF_dir2_1_1  = 4.460686230453e-03 ;
parameter real Out_1_Den_TF_dir2_1_2  = 5.568423204870e-13 ;
parameter real Out_1_Den_TF_dir2_1_3  = 2.576161552007e-23 ;
parameter real Out_1_Num_TF_inv1_1_1  = -9.892880797907e-05 ;
parameter real Out_1_Num_TF_inv1_1_2  = 3.338012087606e-14 ;
parameter real Out_1_Num_TF_inv1_1_3  = -1.425943495954e-26 ;
parameter real Out_1_Den_TF_inv1_1_1  = 1.000000000000e+00 ;
parameter real Out_1_Den_TF_inv1_1_2  = 6.195859370473e-12 ;
parameter real Out_1_Den_TF_inv1_1_3  = 5.453311620995e-23 ;
parameter real Out_1_Num_TF_inv2_1_1  = -3.773617656493e-05 ;
parameter real Out_1_Num_TF_inv2_1_2  = 4.419346963619e-15 ;
parameter real Out_1_Num_TF_inv2_1_3  = 1.692955418853e-27 ;
parameter real Out_1_Den_TF_inv2_1_1  = 1.000000000000e+00 ;
parameter real Out_1_Den_TF_inv2_1_2  = 3.281525489475e-12 ;
parameter real Out_1_Den_TF_inv2_1_3  = 1.019975349910e-23 ;
parameter real Out_1_Num_Zin1_1_1  = 1.000000000000e+00 ;
parameter real Out_1_Num_Zin1_1_2  = 6.678426423279e-11 ;
parameter real Out_1_Den_Zin1_1_1  = 9.391444779809e-02 ;
parameter real Out_1_Den_Zin1_1_2  = 1.477278420010e-12 ;
parameter real Out_1_Den_Zin1_1_3  = 1.148428505854e-26 ;
parameter real Out_1_Num_Zout1_1_1  = 4.273775005404e-01 ;
parameter real Out_1_Num_Zout1_1_2  = 9.548858738211e-10 ;
parameter real Out_1_Num_Zout1_1_3  = 1.677978259085e-22 ;
parameter real Out_1_Den_Zout1_1_1  = 1.000000000000e+00 ;
parameter real Out_1_Den_Zout1_1_2  = 8.204132513609e-12 ;
parameter real Out_1_Den_Zout1_1_3  = 3.352364881738e-23 ;
parameter real Out_1_Num_Zout2_1_1  = 5.555912699692e-01 ;
parameter real Out_1_Num_Zout2_1_2  = 9.508601005656e-10 ;
parameter real Out_1_Num_Zout2_1_3  = 1.578279126858e-22 ;
parameter real Out_1_Den_Zout2_1_1  = 1.000000000000e+00 ;
parameter real Out_1_Den_Zout2_1_2  = 8.179687280301e-12 ;
parameter real Out_1_Den_Zout2_1_3  = 3.307060100070e-23 ;
parameter real Out_1_OffIn11 = -1.000000e-04;
parameter real Out_1_OffIn12 = 2.139866e+00;
parameter real Out_1_OffOut11 = 7.486680e-01;
parameter real Out_1_OffOut12 = -3.200000e-15;
parameter real Out_1_OffOut21 = 6.889038e-01;
parameter real Out_1_OffOut22 = 3.200000e-15;

real Vin1 ;
real Iin1 ;
real Vout1_1 ;
real Iout1_1 ;
real Vout2_1 ;
real Iout2_1 ;
real deltaIin1 ;
real deltaIout1_1 ;
real deltaIout2_1 ;

analog
begin

  Iin1 = I(Vin,);
  V(Vin,) <+ Vin1 ;
  Iout1_1 = I(Vout1,);
  V(Vout1,) <+ Vout1_1 ;
  Iout2_1 = I(Vout2,);
  V(Vout2,) <+ Vout2_1 ;

  deltaIin1 = Iin1 - Out_1_OffIn11;
  deltaIout1_1 = Iout1_1 - Out_1_OffOut12;
  deltaIout2_1 = Iout2_1 - Out_1_OffOut22;

  Vout1_1 = +laplace_nd(deltaIin1,{Out_1_Num_TF_dir1_1_1,Out_1_Num_TF_dir1_1_1}, {Out_1_Den_TF_dir1_1_1,Out_1_Den_TF_dir1_1_2,Out_1_Den_TF_dir1_1_3}) +laplace_nd(deltaIout1_1,{Out_1_Num_Zout1_1_1,Out_1_Num_Zout1_1_2,Out_1_Num_Zout1_1_3}, {Out_1_Den_Zout1_1_1,Out_1_Den_Zout1_1_2,Out_1_Den_Zout1_1_3}) + Out_1_OffOut11;
  Vout2_1 = +laplace_nd(deltaIin1,{Out_1_Num_TF_dir2_1_1,Out_1_Num_TF_dir2_1_2}, {Out_1_Den_TF_dir2_1_1,Out_1_Den_TF_dir2_1_2,Out_1_Den_TF_dir2_1_3}) +laplace_nd(deltaIout2_1,{Out_1_Num_Zout2_1_1,Out_1_Num_Zout2_1_2,Out_1_Num_Zout2_1_3}, {Out_1_Den_Zout2_1_1,Out_1_Den_Zout2_1_2,Out_1_Den_Zout2_1_3}) + Out_1_OffOut21;
  Vin1 =  +laplace_nd(deltaIin1,{Out_1_Num_Zin1_1_1,Out_1_Num_Zin1_1_2}, {Out_1_Den_Zin1_1_1,Out_1_Den_Zin1_1_2,Out_1_Den_Zin1_1_3}) +laplace_nd(deltaIout1_1,{Out_1_Num_TF_inv1_1_1,Out_1_Num_TF_inv1_1_2,Out_1_Num_TF_inv1_1_3}, {Out_1_Den_TF_inv1_1_1,Out_1_Den_TF_inv1_1_2,Out_1_Den_TF_inv1_1_3}) +laplace_nd(deltaIout2_1,{Out_1_Num_TF_inv2_1_1,Out_1_Num_TF_inv2_1_2,Out_1_Num_TF_inv2_1_3}, {Out_1_Den_TF_inv2_1_1,Out_1_Den_TF_inv2_1_2,Out_1_Den_TF_inv2_1_3})+ Out_1_OffIn12;

end
endmodule
