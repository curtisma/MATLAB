simulator( 'spectre )
design(	 "/home/tugui/CADENCE_USERS/AMS_035u_3.7_IC5/Sim/test_v_diff_i_uni/spectre/schematic/netlist/netlist")
resultsDir( "/home/tugui/CADENCE_USERS/AMS_035u_3.7_IC5/Sim/test_v_diff_i_uni/spectre/schematic" )
modelFile(
    '("/home/AMS_3.70/spectre/s35/mcparams.scs" "")
    '("/home/AMS_3.70/spectre/s35/cmos53.scs" "cmostm")
    '("/home/AMS_3.70/spectre/s35/res.scs" "restm")
    '("/home/AMS_3.70/spectre/s35/cap.scs" "captm")
    '("/home/AMS_3.70/spectre/s35/vbic.scs" "biptm")
    '("/home/AMS_3.70/spectre/s35/ind.scs" "indtm")
)
analysis('ac ?start "1e4"  ?stop "1e12"  ?dec "100"  )
analysis('tran ?stop "100n"  )
desVar(	  "g1" 1	)
desVar(	  "g2" -1	)
desVar(	  "g3" 0	)
desVar(	  "I0" 0.0002	)
desVar(	  "l1" 5e-7	)
desVar(	  "l2" 5e-7	)
desVar(	  "per_tr" 1e-8	)
desVar(	  "Vin" 0	)
desVar(	  "Vindc" 1	)
desVar(	  "Vmax" 0	)
desVar(	  "Vmin" 0	)
desVar(	  "vout" 0	)
desVar(	  "voutdc" 2	)
desVar(	  "Vsin" 0	)
desVar(	  "Vsupp" 3.3	)
desVar(	  "w1" 1e-5	)
desVar(	  "w2" 1e-5	)
save( 'i "/E2/MINUS" )
temp( 27 )
run()
selectResult( 'tran )
plot(getData("/E2/MINUS") )
selectResult( 'ac )
plot(getData("/E2/MINUS") )
modelFile(
    '("/home/AMS_3.70/spectre/s35/mcparams.scs" "")
    '("/home/AMS_3.70/spectre/s35/cmos53.scs" "cmostm")
    '("/home/AMS_3.70/spectre/s35/res.scs" "restm")
    '("/home/AMS_3.70/spectre/s35/cap.scs" "captm")
    '("/home/AMS_3.70/spectre/s35/vbic.scs" "biptm")
    '("/home/AMS_3.70/spectre/s35/ind.scs" "indtm")
)
desVar(	  "Vsin" 1	)
run()
selectResult( 'tran )
plot(getData("/E2/MINUS") )
modelFile(
    '("/home/AMS_3.70/spectre/s35/mcparams.scs" "")
    '("/home/AMS_3.70/spectre/s35/cmos53.scs" "cmostm")
    '("/home/AMS_3.70/spectre/s35/res.scs" "restm")
    '("/home/AMS_3.70/spectre/s35/cap.scs" "captm")
    '("/home/AMS_3.70/spectre/s35/vbic.scs" "biptm")
    '("/home/AMS_3.70/spectre/s35/ind.scs" "indtm")
)
save( 'i "/I44/Iout" )
run()
selectResult( 'tran )
plot(getData("/E2/MINUS") getData("/I44/Iout") )
modelFile(
    '("/home/AMS_3.70/spectre/s35/mcparams.scs" "")
    '("/home/AMS_3.70/spectre/s35/cmos53.scs" "cmostm")
    '("/home/AMS_3.70/spectre/s35/res.scs" "restm")
    '("/home/AMS_3.70/spectre/s35/cap.scs" "captm")
    '("/home/AMS_3.70/spectre/s35/vbic.scs" "biptm")
    '("/home/AMS_3.70/spectre/s35/ind.scs" "indtm")
)
desVar(	  "Vmax" 1	)
desVar(	  "Vmin" -1	)
desVar(	  "Vsin" 0	)
save( 'i /I44/Iout )
run()
selectResult( 'tran )
plot(getData("/E2/MINUS") )
