simulator( 'spectre )
design(	 "/home/tugui/CADENCE_USERS/AMS_035u_3.7_IC5/Sim/test_v_diff_i_uni/spectre/schematic/netlist/netlist")
resultsDir( "/home/tugui/CADENCE_USERS/AMS_035u_3.7_IC5/Sim/test_v_diff_i_uni/spectre/schematic" )
modelFile(
    '("/home/AMS_3.70/spectre/s35/mcparams.scs" "")
    '("/home/AMS_3.70/spectre/s35/cmos53.scs" "cmostm")
    '("/home/AMS_3.70/spectre/s35/res.scs" "restm")
    '("/home/AMS_3.70/spectre/s35/cap.scs" "captm")
    '("/home/AMS_3.70/spectre/s35/vbic.scs" "biptm")
    '("/home/AMS_3.70/spectre/s35/ind.scs" "indtm")
)
analysis('tran ?stop "100n"  )
desVar(	  "g1" 1	)
desVar(	  "g2" -1	)
desVar(	  "g3" 0	)
desVar(	  "I0" 0.0002	)
desVar(	  "l1" 5e-7	)
desVar(	  "l2" 5e-7	)
desVar(	  "per_tr" 1e-8	)
desVar(	  "Vin" 0	)
desVar(	  "Vindc" 1	)
desVar(	  "Vmax" 0	)
desVar(	  "Vmin" 0	)
desVar(	  "vout" 0	)
desVar(	  "voutdc" 2	)
desVar(	  "Vsin" 0.1	)
desVar(	  "Vsupp" 3.3	)
desVar(	  "w1" 1e-5	)
desVar(	  "w2" 1e-5	)
save( 'i "/E0/PLUS" "/E1/PLUS" "/E2/PLUS" )
temp( 27 )
run()
selectResult( 'tran )
plot(getData("/Vin1") getData("/Vin2") getData("/E0/PLUS") getData("/E1/PLUS") getData("/E2/PLUS") )
modelFile(
    '("/home/AMS_3.70/spectre/s35/mcparams.scs" "")
    '("/home/AMS_3.70/spectre/s35/cmos53.scs" "cmostm")
    '("/home/AMS_3.70/spectre/s35/res.scs" "restm")
    '("/home/AMS_3.70/spectre/s35/cap.scs" "captm")
    '("/home/AMS_3.70/spectre/s35/vbic.scs" "biptm")
    '("/home/AMS_3.70/spectre/s35/ind.scs" "indtm")
)
run()
selectResult( 'tran )
plot(getData("/E2/PLUS") getData("/E1/PLUS") getData("/E0/PLUS") getData("/Vin2") getData("/Vin1") )
modelFile(
    '("/home/AMS_3.70/spectre/s35/mcparams.scs" "")
    '("/home/AMS_3.70/spectre/s35/cmos53.scs" "cmostm")
    '("/home/AMS_3.70/spectre/s35/res.scs" "restm")
    '("/home/AMS_3.70/spectre/s35/cap.scs" "captm")
    '("/home/AMS_3.70/spectre/s35/vbic.scs" "biptm")
    '("/home/AMS_3.70/spectre/s35/ind.scs" "indtm")
)
desVar(	  "Vmax" 0.1	)
desVar(	  "Vmin" -0.1	)
desVar(	  "Vsin" 0	)
run()
selectResult( 'tran )
plot(getData("/E2/PLUS") getData("/E1/PLUS") getData("/E0/PLUS") getData("/Vin2") getData("/Vin1") )
