simulator( 'spectre )
design(	 "/home/tugui/CADENCE_USERS/AMS_035u_3.7_IC5/Sim/test_v_uni_v_uni/spectre/schematic/netlist/netlist")
resultsDir( "/home/tugui/CADENCE_USERS/AMS_035u_3.7_IC5/Sim/test_v_uni_v_uni/spectre/schematic" )
modelFile(
    '("/home/AMS_3.70/spectre/s35/mcparams.scs" "")
    '("/home/AMS_3.70/spectre/s35/cmos53.scs" "cmostm")
    '("/home/AMS_3.70/spectre/s35/res.scs" "restm")
    '("/home/AMS_3.70/spectre/s35/cap.scs" "captm")
    '("/home/AMS_3.70/spectre/s35/vbic.scs" "biptm")
    '("/home/AMS_3.70/spectre/s35/ind.scs" "indtm")
)
analysis('tran ?stop "100n"  )
desVar(	  "g1" 1	)
desVar(	  "g3" 0	)
desVar(	  "I0" 0.00025	)
desVar(	  "Iout" 0	)
desVar(	  "ioutdc" 0	)
desVar(	  "l1" 5e-7	)
desVar(	  "per_tr" 0	)
desVar(	  "Vin" 0	)
desVar(	  "Vindc" 1.5	)
desVar(	  "Vmax" 0	)
desVar(	  "Vmin" 0	)
desVar(	  "Vsupp" 3.3	)
desVar(	  "w1" 2.5e-5	)
desVar(	  "Vsin" 0	)
save( 'i "/E0/PLUS" )
temp( 27 )
run()
selectResult( 'tran )
plot(getData("/Vout") getData("/Vin") getData("/E0/PLUS") )
modelFile(
    '("/home/AMS_3.70/spectre/s35/mcparams.scs" "")
    '("/home/AMS_3.70/spectre/s35/cmos53.scs" "cmostm")
    '("/home/AMS_3.70/spectre/s35/res.scs" "restm")
    '("/home/AMS_3.70/spectre/s35/cap.scs" "captm")
    '("/home/AMS_3.70/spectre/s35/vbic.scs" "biptm")
    '("/home/AMS_3.70/spectre/s35/ind.scs" "indtm")
)
desVar(	  "per_tr" 1e8	)
run()
selectResult( 'tran )
plot(getData("/Vout") getData("/Vin") getData("/E0/PLUS") )
modelFile(
    '("/home/AMS_3.70/spectre/s35/mcparams.scs" "")
    '("/home/AMS_3.70/spectre/s35/cmos53.scs" "cmostm")
    '("/home/AMS_3.70/spectre/s35/res.scs" "restm")
    '("/home/AMS_3.70/spectre/s35/cap.scs" "captm")
    '("/home/AMS_3.70/spectre/s35/vbic.scs" "biptm")
    '("/home/AMS_3.70/spectre/s35/ind.scs" "indtm")
)
desVar(	  "Vmax" 1	)
desVar(	  "Vmin" -1	)
run()
selectResult( 'tran )
plot(getData("/Vout") getData("/Vin") getData("/E0/PLUS") )
modelFile(
    '("/home/AMS_3.70/spectre/s35/mcparams.scs" "")
    '("/home/AMS_3.70/spectre/s35/cmos53.scs" "cmostm")
    '("/home/AMS_3.70/spectre/s35/res.scs" "restm")
    '("/home/AMS_3.70/spectre/s35/cap.scs" "captm")
    '("/home/AMS_3.70/spectre/s35/vbic.scs" "biptm")
    '("/home/AMS_3.70/spectre/s35/ind.scs" "indtm")
)
desVar(	  "per_tr" 1e-8	)
run()
selectResult( 'tran )
plot(getData("/Vout") getData("/Vin") getData("/E0/PLUS") )
modelFile(
    '("/home/AMS_3.70/spectre/s35/mcparams.scs" "")
    '("/home/AMS_3.70/spectre/s35/cmos53.scs" "cmostm")
    '("/home/AMS_3.70/spectre/s35/res.scs" "restm")
    '("/home/AMS_3.70/spectre/s35/cap.scs" "captm")
    '("/home/AMS_3.70/spectre/s35/vbic.scs" "biptm")
    '("/home/AMS_3.70/spectre/s35/ind.scs" "indtm")
)
desVar(	  "Vmax" 0	)
desVar(	  "Vmin" 0	)
desVar(	  "Vsin" 1	)
run()
selectResult( 'tran )
plot(getData("/Vout") getData("/Vin") getData("/E0/PLUS") )
