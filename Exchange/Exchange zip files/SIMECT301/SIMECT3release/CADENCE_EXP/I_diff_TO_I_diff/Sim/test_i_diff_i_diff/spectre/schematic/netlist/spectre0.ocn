simulator( 'spectre )
design(	 "/home/tugui/CADENCE_USERS/AMS_035u_3.7_IC5/Sim/test_i_diff_i_diff/spectre/schematic/netlist/netlist")
resultsDir( "/home/tugui/CADENCE_USERS/AMS_035u_3.7_IC5/Sim/test_i_diff_i_diff/spectre/schematic" )
modelFile(
    '("/home/AMS_3.70/spectre/s35/mcparams.scs" "")
    '("/home/AMS_3.70/spectre/s35/cmos53.scs" "cmostm")
    '("/home/AMS_3.70/spectre/s35/res.scs" "restm")
    '("/home/AMS_3.70/spectre/s35/cap.scs" "captm")
    '("/home/AMS_3.70/spectre/s35/vbic.scs" "biptm")
    '("/home/AMS_3.70/spectre/s35/ind.scs" "indtm")
)
analysis('tran ?stop "100n"  )
desVar(	  "ar" 9.6	)
desVar(	  "g1" 1	)
desVar(	  "g2" -1	)
desVar(	  "g3" 0	)
desVar(	  "g4" 0	)
desVar(	  "i1" 3.9e-3	)
desVar(	  "i2" 1.7e-3	)
desVar(	  "Iin" 0	)
desVar(	  "iindc" 0.0001	)
desVar(	  "Imax" 0	)
desVar(	  "Imin" 0	)
desVar(	  "Isin" 0.001	)
desVar(	  "l1" 0.35e-6	)
desVar(	  "l2" 0.35e-6	)
desVar(	  "per_tr" 1e-8	)
desVar(	  "r" 1510	)
desVar(	  "v_bpol" 3	)
desVar(	  "vout" 0	)
desVar(	  "voutdc" 2.25	)
desVar(	  "Vsupp" 5	)
desVar(	  "w1" 15e-6	)
desVar(	  "w2" 10e-6	)
desVar(	  "ga" 0.9986	)
desVar(	  "gb" 0.9738	)
save( 'i "/E2/PLUS" "/E1/PLUS" "/V2/PLUS" "/V1/PLUS" )
temp( 27 )
run()
selectResult( 'tran )
plot(getData("/E2/PLUS") getData("/E1/PLUS") getData("/V2/PLUS") getData("/V1/PLUS") getData("/Vin2") getData("/Vin1") )
modelFile(
    '("/home/AMS_3.70/spectre/s35/mcparams.scs" "")
    '("/home/AMS_3.70/spectre/s35/cmos53.scs" "cmostm")
    '("/home/AMS_3.70/spectre/s35/res.scs" "restm")
    '("/home/AMS_3.70/spectre/s35/cap.scs" "captm")
    '("/home/AMS_3.70/spectre/s35/vbic.scs" "biptm")
    '("/home/AMS_3.70/spectre/s35/ind.scs" "indtm")
)
save( 'i "/V2/MINUS" "/V1/MINUS" )
save( 'i /V2/PLUS /V1/PLUS )
run()
selectResult( 'tran )
plot(getData("/E2/PLUS") getData("/E1/PLUS") getData("/Vin2") getData("/Vin1") getData("/V2/MINUS") getData("/V1/MINUS") )
