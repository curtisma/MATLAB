simulator( 'spectre )
design(	 "/home/tugui/CADENCE_USERS/AMS_035u_3.7_IC5/Sim/test_i_diff_i_diff/spectre/schematic/netlist/netlist")
resultsDir( "/home/tugui/CADENCE_USERS/AMS_035u_3.7_IC5/Sim/test_i_diff_i_diff/spectre/schematic" )
modelFile(
    '("/home/AMS_3.70/spectre/s35/mcparams.scs" "")
    '("/home/AMS_3.70/spectre/s35/cmos53.scs" "cmostm")
    '("/home/AMS_3.70/spectre/s35/res.scs" "restm")
    '("/home/AMS_3.70/spectre/s35/cap.scs" "captm")
    '("/home/AMS_3.70/spectre/s35/vbic.scs" "biptm")
    '("/home/AMS_3.70/spectre/s35/ind.scs" "indtm")
)
analysis('ac ?start "1e2"  ?stop "1e12"  ?dec "100"  )
desVar(	  "g1" 1	)
desVar(	  "g2" -1	)
desVar(	  "g3" 0	)
desVar(	  "g4" 0	)
desVar(	  "Iin" 0	)
desVar(	  "iindc" 0.0001	)
desVar(	  "Itr_max" 0	)
desVar(	  "Itr_min" 0	)
desVar(	  "per_tr" 0	)
desVar(	  "vout" 0	)
desVar(	  "voutdc" 2.25	)
desVar(	  "Vsupp" 5	)
save( 'i "/E1/MINUS" "/E0/MINUS" )
temp( 27 )
run()
selectResult( 'ac )
plot(getData("/E1/MINUS") getData("/E0/MINUS") )
modelFile(
    '("/home/AMS_3.70/spectre/s35/mcparams.scs" "")
    '("/home/AMS_3.70/spectre/s35/cmos53.scs" "cmostm")
    '("/home/AMS_3.70/spectre/s35/res.scs" "restm")
    '("/home/AMS_3.70/spectre/s35/cap.scs" "captm")
    '("/home/AMS_3.70/spectre/s35/vbic.scs" "biptm")
    '("/home/AMS_3.70/spectre/s35/ind.scs" "indtm")
)
run()
selectResult( 'ac )
plot(getData("/E1/MINUS") getData("/E0/MINUS") )
modelFile(
    '("/home/AMS_3.70/spectre/s35/mcparams.scs" "")
    '("/home/AMS_3.70/spectre/s35/cmos53.scs" "cmostm")
    '("/home/AMS_3.70/spectre/s35/res.scs" "restm")
    '("/home/AMS_3.70/spectre/s35/cap.scs" "captm")
    '("/home/AMS_3.70/spectre/s35/vbic.scs" "biptm")
    '("/home/AMS_3.70/spectre/s35/ind.scs" "indtm")
)
run()
selectResult( 'ac )
plot(getData("/E1/MINUS") getData("/E0/MINUS") )
