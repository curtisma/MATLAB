simulator( 'spectre )
design(	 "/home/tugui/CADENCE_USERS/AMS_035u_3.7_IC5/Sim/test_i_uni_v_diff/spectre/schematic/netlist/netlist")
resultsDir( "/home/tugui/CADENCE_USERS/AMS_035u_3.7_IC5/Sim/test_i_uni_v_diff/spectre/schematic" )
modelFile(
    '("/home/AMS_3.70/spectre/s35/mcparams.scs" "")
    '("/home/AMS_3.70/spectre/s35/cmos53.scs" "cmostm")
    '("/home/AMS_3.70/spectre/s35/res.scs" "restm")
    '("/home/AMS_3.70/spectre/s35/cap.scs" "captm")
    '("/home/AMS_3.70/spectre/s35/vbic.scs" "biptm")
    '("/home/AMS_3.70/spectre/s35/ind.scs" "indtm")
)
analysis('tran ?stop "100n"  )
desVar(	  "ar" 9.6	)
desVar(	  "g1" 1	)
desVar(	  "g2" -1	)
desVar(	  "g3" 0	)
desVar(	  "g4" 0	)
desVar(	  "i1" 3.9e-3	)
desVar(	  "i2" 1.7e-3	)
desVar(	  "Iin" 0	)
desVar(	  "iindc" 0.0001	)
desVar(	  "Imax" 0	)
desVar(	  "Imin" 0	)
desVar(	  "Isin" 0	)
desVar(	  "l1" 0.35e-6	)
desVar(	  "l2" 0.35e-6	)
desVar(	  "per_tr" 1e-8	)
desVar(	  "r" 1510	)
desVar(	  "v_bpol" 3	)
desVar(	  "Vsupp" 5	)
desVar(	  "w1" 15e-6	)
desVar(	  "w2" 10e-6	)
desVar(	  "ga" 0.9986	)
desVar(	  "gb" 0.9738	)
desVar(	  "area1" 4.8	)
desVar(	  "area2" 16	)
desVar(	  "c" 75f	)
desVar(	  "i3" 200u	)
desVar(	  "i4" 4m	)
desVar(	  "Iout" 0	)
desVar(	  "ioutdc" 3.2f	)
desVar(	  "r1" 500	)
desVar(	  "r2" 400	)
temp( 27 )
run()
selectResult( 'tran )
plot(getData("/net031") getData("/net030") )
modelFile(
    '("/home/AMS_3.70/spectre/s35/mcparams.scs" "")
    '("/home/AMS_3.70/spectre/s35/cmos53.scs" "cmostm")
    '("/home/AMS_3.70/spectre/s35/res.scs" "restm")
    '("/home/AMS_3.70/spectre/s35/cap.scs" "captm")
    '("/home/AMS_3.70/spectre/s35/vbic.scs" "biptm")
    '("/home/AMS_3.70/spectre/s35/ind.scs" "indtm")
)
analysis('ac ?start "1e4"  ?stop "1e12"  ?dec "100"  )
run()
selectResult( 'ac )
plot(getData("/net031") getData("/net030") )
modelFile(
    '("/home/AMS_3.70/spectre/s35/mcparams.scs" "")
    '("/home/AMS_3.70/spectre/s35/cmos53.scs" "cmostm")
    '("/home/AMS_3.70/spectre/s35/res.scs" "restm")
    '("/home/AMS_3.70/spectre/s35/cap.scs" "captm")
    '("/home/AMS_3.70/spectre/s35/vbic.scs" "biptm")
    '("/home/AMS_3.70/spectre/s35/ind.scs" "indtm")
)
analysis('tran ?stop "100n"  )
desVar(	  "Isin" 1m	)
run()
selectResult( 'tran )
plot(getData("/net031") getData("/net030") )
