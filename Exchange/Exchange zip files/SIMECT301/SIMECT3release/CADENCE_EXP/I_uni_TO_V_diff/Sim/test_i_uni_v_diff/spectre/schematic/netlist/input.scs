// Design: sigmadelta_local/test_i_uni_v_diff
simulator lang=spectre
global 0
include "/home/ic5.1/tools/dfII/samples/artist/ahdlLib/quantity.spectre"
parameters r2=400 r1=500 ioutdc=3.2f Iout=0 i4=4m i3=200u c=75f area2=16 area1=4.8 gb=0.9738 ga=0.9986 w2=10e-6 w1=15e-6 Vsupp=5 v_bpol=3 r=1510 per_tr=1e-8 l2=0.35e-6 l1=0.35e-6 Isin=1m Imin=0 Imax=0 iindc=0.0001 Iin=0 i2=1.7e-3 i1=3.9e-3 g4=0 g3=0 g2=-1 g1=1 ar=9.6
include "/home/AMS_3.70/spectre/s35/mcparams.scs"
include "/home/AMS_3.70/spectre/s35/cmos53.scs" section=cmostm
include "/home/AMS_3.70/spectre/s35/res.scs" section=restm
include "/home/AMS_3.70/spectre/s35/cap.scs" section=captm
include "/home/AMS_3.70/spectre/s35/vbic.scs" section=biptm
include "/home/AMS_3.70/spectre/s35/ind.scs" section=indtm

// sigmadelta_local/simect_i_uni_v_diff_sch/schematic
subckt simect_i_uni_v_diff_sch Iin Vout\+ Vout\- Vsupp gnd
    I24 (net0176 net0238 gnd gnd) npn254h5 area=area1 m=1
    I20 (Vsupp net0188 Vout\- 0) npn254h5 area=area2 m=1
    I21 (Vsupp net0176 Vout\+ 0) npn254h5 area=area2 m=1
    I15 (net0188 net043 0 0) npn254h5 area=area1 m=1
    C6 (net043 Vout\-) capacitor c=c
    C0 (net0238 Vout\+) capacitor c=c
    R3 (net0238 Vout\+) resistor r=r2
    R2 (net043 Vout\-) resistor r=r1
    R1 (net062 net070) resistor r=r
    R0 (net037 net0103) resistor r=r
    MN8 (net0238 net038 gnd gnd) modn w=w2*ga*gb l=l2 ng=1
    MN6 (net051 net051 gnd gnd) modn w=w2 l=l2 ng=1
    MN2 (net043 net051 gnd gnd) modn w=w2*ga*gb l=l2 ng=1
    MN7 (net038 net038 gnd gnd) modn w=w2 l=l2 ng=1
    Q0 (net0103 net0112 Iin gnd) npn143h5 area=ar m=1
    Q1 (net062 net0172 net092 gnd) npn143h5 area=ar m=1
    MP11 (net062 net062 Vsupp Vsupp) modp w=2*w1 l=l1 ng=1
    MP12 (net043 net070 Vsupp Vsupp) modp w=w1*ga*(2-gb) l=l1 ng=1
    MP0 (net0238 net037 Vsupp Vsupp) modp w=w1*ga*(2-gb) l=l1 ng=1
    MP1 (net0103 net0103 Vsupp Vsupp) modp w=2*w1 l=l1 ng=1
    MP9 (net051 net0103 Vsupp Vsupp) modp w=w1 l=l1 ng=1
    MP10 (net038 net062 Vsupp Vsupp) modp w=w1 l=l1 ng=1
    I25 (Vout\+ gnd) isource dc=i4 type=dc
    I23 (Vsupp net0188) isource dc=i3 type=dc
    I26 (Vsupp net0176) isource dc=i3 type=dc
    I30 (Vout\- gnd) isource dc=i4 type=dc
    I3 (net092 gnd) isource dc=i1 type=dc
    I2 (Iin gnd) isource dc=i1 type=dc
    I1 (Vsupp net062) isource dc=i1-i2 type=dc
    I0 (Vsupp net0103) isource dc=i1-i2 type=dc
    V7 (net0172 gnd) vsource dc=v_bpol type=dc
    V2 (net0112 gnd) vsource dc=v_bpol type=dc
ends simect_i_uni_v_diff_sch

// sigmadelta_local/test_i_uni_v_diff/schematic
F5 (0 net027) cccs gain=1 probe=V20
I42 (Vin Vout1 Vout2 net0106 0) simect_i_uni_v_diff_sch
V4 (net025 0) vsource type=sine ampl=Isin freq=1/per_tr
V23 (net036 net025) vsource dc=Iin mag=1 type=pulse val0=Imin val1=Imax period=per_tr width=per_tr/2
G0 (0 net034 net036 0) vccs gm=g1
G1 (0 net045 net046 0) vccs gm=g3
G2 (0 net027 net046 0) vccs gm=g4
I1 (0 net051) isource dc=ioutdc type=dc
I0 (0 net011) isource dc=iindc type=dc
V20 (net045 net051) vsource dc=0 type=dc
V1 (Vin net034) vsource dc=0 type=dc
V19 (net046 0) vsource dc=Iout mag=1 type=dc
V2 (Vout1 net045) vsource dc=0 type=dc
V3 (Vout2 net027) vsource dc=0 type=dc
V0 (net0106 0) vsource dc=Vsupp type=dc
V14 (net034 net011) vsource dc=0 type=dc
simulatorOptions options reltol=100e-6 temp=27 homotopy=all limit=delta compatible=spice2
tran tran stop=100n errpreset=conservative
save V1:p
